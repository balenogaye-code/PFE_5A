* Simulation de l'inverseur (layout extrait de Magic)
.lib /usr/local/share/pdk/sky130A/libs.tech/ngspice/sky130.lib.spice tt

.include inverter_pex.spice

* Instantiate the inverter

Xinv VDD IN OUT VSS inverter

* Set gnd and power
Vss VSS 0 0
Vdd VDD VSS 1.8

* create pulse
Vin IN VSS pulse(0 1.8 1p 10p 10p 1n 2n)

.tran 10e-12 2e-09 0e-00

.control
run
plot IN OUT
plot i(Vdd)
.endc

.end
